* 5.0 V DC to 2.50 V output divider (no load)
* Requirement: V(out) = 2.50 V ±0.05 V with no load connected

V1 IN 0 DC 5

R1 IN OUT 10k
R2 OUT 0 10k

.op
.meas OP VOUT FIND V(OUT)

.end
